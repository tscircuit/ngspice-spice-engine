* Self-contained ngspice repro generated from lib/MSPM0G3507
* Generated by spice-repros/generate-repros.mjs
* Circuit JSON to SPICE Netlist
* MSPM0_OPA - Rev. A
* Created by Tim Claycomb; February 01, 2023
* Created with Green-Williams-Lis Op Amp Macro-model Architecture
* Copyright 2023 by Texas Instruments Corporation
******************************************************
* MACRO-MODEL SIMULATED PARAMETERS:
******************************************************
* OPEN-LOOP GAIN AND PHASE VS. FREQUENCY  WITH RL, CL EFFECTS (Aol)
* UNITY GAIN BANDWIDTH (GBW)
* INPUT COMMON-MODE REJECTION RATIO VS. FREQUENCY (CMRR)
* DIFFERENTIAL INPUT IMPEDANCE (Zid)
* COMMON-MODE INPUT IMPEDANCE (Zic)
* OPEN-LOOP OUTPUT IMPEDANCE VS. FREQUENCY (Zo)
* OUTPUT CURRENT THROUGH THE SUPPLY (Iout)
* INPUT VOLTAGE NOISE DENSITY VS. FREQUENCY (en)
* INPUT CURRENT NOISE DENSITY VS. FREQUENCY (in)
* OUTPUT VOLTAGE SWING vs. OUTPUT CURRENT (Vo)
* SHORT-CIRCUIT OUTPUT CURRENT (Isc)
* QUIESCENT CURRENT (Iq)
* SETTLING TIME VS. CAPACITIVE LOAD (ts)
* SLEW RATE (SR)
* SMALL SIGNAL OVERSHOOT VS. CAPACITIVE LOAD
* LARGE SIGNAL RESPONSE
* OVERLOAD RECOVERY TIME (tor)
* INPUT BIAS CURRENT (Ib)
* INPUT OFFSET CURRENT (Ios)
* INPUT OFFSET VOLTAGE (Vos)
* INPUT COMMON-MODE VOLTAGE RANGE (Vcm)
* INPUT OFFSET VOLTAGE VS. INPUT COMMON-MODE VOLTAGE (Vos vs. Vcm)
* INPUT/OUTPUT ESD CELLS (ESDin, ESDout)
******************************************************
.subckt MSPM0_OPA INP INN VCC VEE OUT
******************************************************

I_OS        ESDn MID 130P
I_B         21 MID 130P
V_GRp       55 MID 120
V_GRn       56 MID -120
V_ISCp      49 MID 40
V_ISCn      50 MID -40
V_ORn       44 VCLP -2.8
V11         54 43 0
V_ORp       42 VCLP 7.5
V12         53 41 0
V4          26 OUT 0
VCM_MIN     77 VEE_B -100M
VCM_MAX     78 VCC_B -300M
I_Q         VCC VEE 400U
V_OS        36 21 450U
XIn11       ESDn MID FEMT_0
Xi_n        MID 21 FEMT_0
Xe_n        ESDp 21 VNSE_0
C23         22 MID 19F IC=0
R68         MID 22 1MEG
GVCCS5      22 MID VSENSE MID  -1U
XU2         23 MID MID CLAMP VCCS_LIM_2_0
C20         CLAMP MID 23N IC=0
R67         MID CLAMP 1MEG
R44         MID 23 1MEG
XU1         24 25 MID 23 VCCS_LIM_1_0
Rx          26 27 384K
Rdummy      MID 26 38.4K
R66         27 MID 1
XVCCS_LIM_ZO 28 MID MID 27 VCCS_LIM_ZO_0
R65         28 MID 1
GVCCS4      28 MID 29 MID  -251.3
C22         30 29 399F IC=0
R64         29 MID 39.96
R63         29 30 10K
R62         30 MID 1
GVCCS3      30 MID 31 MID  -110
C21         32 31 500N IC=0
R51         31 MID 475
R50         31 32 10K
Rdc         32 MID 1
G_Aol_Zo    32 MID CL_CLAMP 26  16
C14         33 34 126.4P IC=0
R49         34 MID 316.3
R48         33 34 100MEG
Rsrc        33 MID 1
G_adjust    33 MID ESDp MID  767.1M
XVOS_VCM    35 36 VCC VEE VOS_SRC_0
SW11        ESDp ESDn ESDp ESDn  S_VSWITCH_1
SW10        ESDn ESDp ESDn ESDp  S_VSWITCH_2
S5          VEE ESDp VEE ESDp  S_VSWITCH_3
S4          VEE ESDn VEE ESDn  S_VSWITCH_4
S2          ESDn VCC ESDn VCC  S_VSWITCH_5
S3          ESDp VCC ESDp VCC  S_VSWITCH_6
C28         37 MID 1P IC=0
R77         38 37 100
C27         39 MID 1P IC=0
R76         40 39 100
R75         MID 41 1
GVCCS8      41 MID 42 MID  -1
R74         43 MID 1
GVCCS7      43 MID 44 MID  -1
R61         MID 45 3.9272K
C16         45 46 2.004P IC=0
R58         46 45 100MEG
GVCCS2      46 MID VEE_B MID  412.1M
R57         MID 46 1
R56         MID 47 3.9272K
C15         47 48 2.004P IC=0
R55         48 47 100MEG
GVCCS1      48 MID VCC_B MID  412.1M
R54         MID 48 1
XIQp        VIMON MID MID VCC VCCS_LIMIT_IQ_0
XIQn        MID VIMON VEE MID VCCS_LIMIT_IQ_0
C_DIFF      ESDp ESDn 1.5P IC=0
XCL_AMP     49 50 VIMON MID 51 52 CLAMP_AMP_LO_0
SOR_SWp     CLAMP 53 CLAMP 53  S_VSWITCH_7
SOR_SWn     54 CLAMP 54 CLAMP  S_VSWITCH_8
XGR_AMP     55 56 57 MID 58 59 CLAMP_AMP_HI_0
R39         55 MID 1T
R37         56 MID 1T
R42         VSENSE 57 1M
C19         57 MID 1F IC=0
R38         58 MID 1
R36         MID 59 1
R40         58 60 1M
R41         59 61 1M
C17         60 MID 1F IC=0
C18         MID 61 1F IC=0
XGR_SRC     60 61 CLAMP MID VCCS_LIM_GR_0
R21         51 MID 1
R20         MID 52 1
R29         51 62 1M
R30         52 63 1M
C9          62 MID 1F IC=0
C8          MID 63 1F IC=0
XCL_SRC     62 63 CL_CLAMP MID VCCS_LIM_4_0
R22         49 MID 1T
R19         MID 50 1T
XCLAWp      VIMON MID 64 VCC_B VCCS_LIM_CLAW+_0
XCLAWn      MID VIMON VEE_B 65 VCCS_LIM_CLAW-_0
R12         64 VCC_B 1K
R16         64 66 1M
R13         VEE_B 65 1K
R17         67 65 1M
C6          67 MID 1F IC=0
C5          MID 66 1F IC=0
G2          VCC_CLP MID 66 MID  -1M
R15         VCC_CLP MID 1K
G3          VEE_CLP MID 67 MID  -1M
R14         MID VEE_CLP 1K
XCLAW_AMP   VCC_CLP VEE_CLP VOUT_S MID 68 69 CLAMP_AMP_LO_1
R26         VCC_CLP MID 1T
R23         VEE_CLP MID 1T
R25         68 MID 1
R24         MID 69 1
R27         68 70 1M
R28         69 71 1M
C11         70 MID 1F IC=0
C10         MID 71 1F IC=0
XCLAW_SRC   70 71 CLAW_CLAMP MID VCCS_LIM_3_0
H2          40 MID V11 -1
H3          38 MID V12 1
C12         SW_OL MID 100P IC=0
R32         72 SW_OL 100
R31         72 MID 1
XOL_SENSE   MID 72 39 37 OL_SENSE_0
S1          32 31 SW_OL MID  S_VSWITCH_9
H1          73 MID V4 1K
S7          VEE OUT VEE OUT  S_VSWITCH_10
S6          OUT VCC OUT VCC  S_VSWITCH_11
R11         MID 74 1T
R18         74 VOUT_S 100
C7          VOUT_S MID 1N IC=0
E5          74 MID OUT MID  1
C13         VIMON MID 1N IC=0
R33         73 VIMON 100
R10         MID 73 1T
R47         75 VCLP 100
C24         VCLP MID 100P IC=0
E4          75 MID CL_CLAMP MID  1
R46         MID CL_CLAMP 1K
G9          CL_CLAMP MID CLAW_CLAMP MID  -1M
R45         MID CLAW_CLAMP 1K
G8          CLAW_CLAMP MID 22 MID  -1M
R43         MID VSENSE 1K
G15         VSENSE MID CLAMP MID  -1M
C4          24 MID 1F IC=0
R9          24 76 1M
R7          MID 77 1T
R6          78 MID 1T
R8          MID 76 1
XVCM_CLAMP  79 MID 76 MID 78 77 VCCS_EXT_LIM_0
E1          MID 0 80 0  1
R89         VEE_B 0 1
R5          81 VEE_B 1M
C3          81 0 1F IC=0
R60         80 81 1MEG
C1          80 0 1N IC=0
R3          80 0 1T
R59         82 80 1MEG
C2          82 0 1F IC=0
R4          VCC_B 82 1M
R88         VCC_B 0 1
G17         VEE_B 0 VEE 0  -1
G16         VCC_B 0 VCC 0  -1
R_PSR       83 79 1K
G_PSR       79 83 47 45  -1M
R2          25 ESDn 1M
R1          83 35 1M
R_CMR       84 35 1K
G_CMR       35 84 34 MID  -1M
C_CMn       ESDn MID 1.6P IC=0
C_CMp       MID ESDp 3P IC=0
R53         ESDn MID 1T
R52         MID ESDp 1T
R35         INN ESDn 10M
R34         INP ESDp 10M

.MODEL S_VSWITCH_1 SW (RON=50 ROFF=1T VON=700M VOFF=0)
.MODEL S_VSWITCH_2 SW (RON=50 ROFF=1T VON=700M VOFF=0)
.MODEL S_VSWITCH_3 SW (RON=50 ROFF=1T VON=500M VOFF=100M)
.MODEL S_VSWITCH_4 SW (RON=50 ROFF=1T VON=500M VOFF=100M)
.MODEL S_VSWITCH_5 SW (RON=50 ROFF=1T VON=500M VOFF=100M)
.MODEL S_VSWITCH_6 SW (RON=50 ROFF=1T VON=500M VOFF=100M)

.MODEL S_VSWITCH_7 SW (RON=10M ROFF=1T VON=10M VOFF=0)
.MODEL S_VSWITCH_8 SW (RON=10M ROFF=1T VON=10M VOFF=0)

.MODEL S_VSWITCH_9 SW (RON=1M ROFF=1T VON=500M VOFF=100M)
.MODEL S_VSWITCH_10 SW (RON=50 ROFF=1T VON=500M VOFF=100M)
.MODEL S_VSWITCH_11 SW (RON=50 ROFF=1T VON=500M VOFF=100M)

.ENDS MSPM0_OPA

* FEMT - INPUT CURRENT NOISE IN FA/RT-HZ
.SUBCKT FEMT_0  1 2
* INPUT VARIABLES
* SET UP 1/F NOISE
* FLWF = 1/F FREQUENCY IN HZ
.PARAM FLWF=0.1
* NLFF = CURRENT NOISE DENSITY AT 1/F FREQUENCY IN FA/RT(HZ)
.PARAM NLFF=1.84E5
* SET UP BROADBAND NOISE
* NVRF = BROADBAND CURRENT NOISE DENSITY IN FA/RT(HZ)
.PARAM NVRF=1.2E3
* CALCULATED VALUES
.PARAM GLFF={PWR(FLWF,0.25)*NLFF/1164}
.PARAM RNVF={1.184*PWR(NVRF,2)}
.MODEL DVNF D KF={PWR(FLWF,0.5)/1E11} IS=1.0E-16
* CIRCUIT CONNECTIONS
I1 0 7 10E-3
I2 0 8 10E-3
D1 7 0 DVNF
D2 8 0 DVNF
E1 3 6 7 8 {GLFF}
R1 3 0 1E9
R2 3 0 1E9
R3 3 6 1E9
E2 6 4 5 0 10
R4 5 0 {RNVF}
R5 5 0 {RNVF}
R6 3 4 1E9
R7 4 0 1E9
G1 1 2 3 4 1E-6
.ENDS

* VNSE - INPUT VOLTAGE NOISE IN NV/RT-HZ
.SUBCKT VNSE_0  1 2
* INPUT VARIABLES
* SET UP 1/F NOISE
* FLW = 1/F FREQUENCY IN HZ
.PARAM FLW=0.1
* NLF = VOLTAGE NOISE DENSITY AT 1/F FREQUENCY IN NV/RT(HZ)
.PARAM NLF=18.4E3
* SET UP BROADBAND NOISE
* NVR = BROADBAND VOLTAGE NOISE DENSITY IN NV/RT(HZ)
.PARAM NVR=40
* CALCULATED VALUES
.PARAM GLF={PWR(FLW,0.25)*NLF/1164}
.PARAM RNV={1.184*PWR(NVR,2)}
.MODEL DVN D KF={PWR(FLW,0.5)/1E11} IS=1.0E-16
* CIRCUIT CONNECTIONS
I1 0 7 10E-3
I2 0 8 10E-3
D1 7 0 DVN
D2 8 0 DVN
E1 3 6 7 8 {GLF}
R1 3 0 1E9
R2 3 0 1E9
R3 3 6 1E9
E2 6 4 5 0 10
R4 5 0 {RNV}
R5 5 0 {RNV}
R6 3 4 1E9
R7 4 0 1E9
E3 1 2 3 4 1
.ENDS

* VOLTAGE-CONTROLLED CURRENT SOURCE WITH LIMITS - AOL SECOND STAGE
.SUBCKT VCCS_LIM_2_0  VC+ VC- IOUT+ IOUT-
.PARAM GAIN = 11.8E-3
.PARAM IPOS = 0.107
.PARAM INEG = -0.107
G1 IOUT+ IOUT- VALUE={LIMIT(GAIN*V(VC+,VC-),INEG,IPOS)}
.ENDS

* VOLTAGE-CONTROLLED CURRENT SOURCE WITH LIMITS - AOL FIRST STAGE
.SUBCKT VCCS_LIM_1_0  VC+ VC- IOUT+ IOUT-
.PARAM GAIN = 1E-4
.PARAM IPOS = .5
.PARAM INEG = -.5
G1 IOUT+ IOUT- VALUE={LIMIT(GAIN*V(VC+,VC-),INEG,IPOS)}
.ENDS

* VOLTAGE-CONTROLLED CURRENT SOURCE WITH LIMITS - ZO OUTPUT
.SUBCKT VCCS_LIM_ZO_0  VC+ VC- IOUT+ IOUT-
.PARAM GAIN = -1
.PARAM IPOS = 30E3
.PARAM INEG = -30E3
G1 IOUT+ IOUT- VALUE={LIMIT(GAIN*V(VC+,VC-),INEG,IPOS)}
.ENDS

* VOLTAGE SOURCE (TABLE-DEFINED) - VOS
.SUBCKT VOS_SRC_0  V+ V- REF+ REF-
E1 V+ 1 VALUE={0}
E2 1 V- VALUE={0}
.ENDS VOS_SRC_0

* VOLTAGE-CONTROLLED SOURCE WITH LIMITS - IOUT DRAW
.SUBCKT VCCS_LIMIT_IQ_0  VC+ VC- IOUT+ IOUT-
.PARAM GAIN = 1E-3
G1 IOUT- IOUT+ VALUE={((V(VC+,VC-)<=0) ? 0 : GAIN*V(VC+,VC-))}
.ENDS

* CLAMP AMP - CLAW AND CURRENT LIMIT CLAMP
.SUBCKT CLAMP_AMP_LO_0  VC+ VC- VIN COM VO+ VO-
*  PINS     CLAMP V+  CLAMP V-  VIN  COM   VOUT+  VOUT-
.PARAM G=1
* OUTPUT G(COM,0) WHEN CONDITION NOT MET
GVO+ COM VO+ VALUE = {MAX(((V(VIN,COM)-V(VC+,COM))*G),0)}
GVO- COM VO- VALUE = {MAX(((V(VC-,COM)-V(VIN,COM))*G),0)}
.ENDS

* CLAMP AMP - OVERLOAD AND GROSS CLAMP
.SUBCKT CLAMP_AMP_HI_0  VC+ VC- VIN COM VO+ VO-
*  PINS     CLAMP V+  CLAMP V-  VIN  COM   VOUT+  VOUT-
.PARAM G=10
* OUTPUT G(COM,0) WHEN CONDITION NOT MET
GVO+ COM VO+ VALUE = {MAX(((V(VIN,COM)-V(VC+,COM))*G),0)}
GVO- COM VO- VALUE = {MAX(((V(VC-,COM)-V(VIN,COM))*G),0)}
.ENDS

* VOLTAGE-CONTROLLED CURRENT SOURCE WITH LIMITS - GROSS CLAMP
.SUBCKT VCCS_LIM_GR_0  VC+ VC- IOUT+ IOUT-
.PARAM GAIN = 1
.PARAM IPOS = 1
.PARAM INEG = -1
G1 IOUT+ IOUT- VALUE={LIMIT(GAIN*V(VC+,VC-),INEG,IPOS)}
.ENDS

* VOLTAGE-CONTROLLED CURRENT SOURCE WITH LIMITS - CURRENT LIMIT CLAMP
.SUBCKT VCCS_LIM_4_0  VC+ VC- IOUT+ IOUT-
.PARAM GAIN = 1
.PARAM IPOS = 240E-3
.PARAM INEG = -240E-3
G1 IOUT+ IOUT- VALUE={LIMIT(GAIN*V(VC+,VC-),INEG,IPOS)}
.ENDS

* VOLTAGE-CONTROLLED CURRENT SOURCE (TABLE-DEFINED) - CLAW+
.SUBCKT VCCS_LIM_CLAW+_0  VC+ VC- IOUT+ IOUT-
G1 IOUT+ IOUT- VALUE={LIMIT(9.375e-5*ABS(V(VC+,VC-))+1e-5,1e-5,3e-3)}
.ENDS

* VOLTAGE-CONTROLLED CURRENT SOURCE (TABLE-DEFINED) - CLAW-
.SUBCKT VCCS_LIM_CLAW-_0  VC+ VC- IOUT+ IOUT-
G1 IOUT+ IOUT- VALUE={LIMIT(9.375e-5*ABS(V(VC+,VC-))+1e-5,1e-5,3e-3)}
.ENDS

* CLAMP AMP - CLAW AND CURRENT LIMIT CLAMP
.SUBCKT CLAMP_AMP_LO_1  VC+ VC- VIN COM VO+ VO-
*  PINS     CLAMP V+  CLAMP V-  VIN  COM   VOUT+  VOUT-
.PARAM G=1
* OUTPUT G(COM,0) WHEN CONDITION NOT MET
GVO+ COM VO+ VALUE = {MAX(((V(VIN,COM)-V(VC+,COM))*G),0)}
GVO- COM VO- VALUE = {MAX(((V(VC-,COM)-V(VIN,COM))*G),0)}

.ENDS

* VOLTAGE-CONTROLLED CURRENT SOURCE WITH LIMITS - CLAW CLAMP
.SUBCKT VCCS_LIM_3_0  VC+ VC- IOUT+ IOUT-
.PARAM GAIN = 1
.PARAM IPOS = 240E-3
.PARAM INEG = -240E-3
G1 IOUT+ IOUT- VALUE={LIMIT(GAIN*V(VC+,VC-),INEG,IPOS)}
.ENDS

* OVERLOAD SENSE FOR ZO SWITCHES
.SUBCKT OL_SENSE_0  COM SW+ OLN  OLP
* PINS          COM SW+ OLN OLP
GSW+ COM SW+ VALUE = {LIMIT((V(OLN,COM)-9M)*1E3,0,1)+LIMIT((V(OLP,COM)-9M)*1E3,0,1)}
.ENDS

* VOLTAGE-CONTROLLED CURRENT SOURCE WITH EXTERNAL LIMITS - VCM CLAMP
.SUBCKT VCCS_EXT_LIM_0  VIN+ VIN- IOUT- IOUT+ VP+ VP-
.PARAM GAIN = 1
G1 IOUT+ IOUT- VALUE={LIMIT(GAIN*V(VIN+,VIN-),V(VP-,VIN-), V(VP+,VIN-))}
.ENDS

.END

CC1 N10 0 10U
CC2 N10 0 100N
CC3 N6 0 470N
RR1 N9 N10 47K
CC4 N9 0 10N
RR2 N11 0 100K
RR_OPA_FB N3 N5 10K
RR_OPA_G N5 0 10K
RR_OPA_LOAD N3 0 10K
RR3 N8 N10 4.7K
RR4 N7 N10 4.7K
Vsimulation_voltage_source_0 N10 0 DC 3.3
Vsimulation_voltage_source_1 N4 0 DC 0.5
Xsimulation_spice_subcircuit_0 N4 N5 N10 0 N3 MSPM0_OPA
.PRINT TRAN V(N4) V(N3)
.tran 0.000001 0.0001 UIC
.END
