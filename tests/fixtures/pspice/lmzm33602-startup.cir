* LMZM33602: 24 V input ramp, 12 V feedback divider, 24 ohm load
* TI model: https://www.ti.com/lit/zip/snvmbf8
Vinput vin 0 PWL(0 0 1m 24)
Xreg 0 dnc boot_supply vin fb 0 0 0 0 pgood rt sw sw sw vin out out out LMZM33602_TRANS
Rrt rt 0 44.2k
Rtop out fb 110k
Rbottom fb 0 10k
Cin vin 0 10u
Cout out 0 54u
Rload out 0 24
.print tran V(out)
.save V(out)
* Convergence conductance for the ideal-switch model during startup.
.options gmin=1e-8
.tran 1u 1m

*$
* LMZM33602
*****************************************************************************
* (C) Copyright 2017 Texas Instruments Incorporated. All rights reserved.
*****************************************************************************
** This model is designed as an aid for customers of Texas Instruments.
** TI and its licensors and suppliers make no warranties, either expressed
** or implied, with respect to this model, including the warranties of
** merchantability or fitness for a particular purpose.  The model is
** provided solely on an "as is" basis.  The entire risk as to its quality
** and performance is with the customer
*****************************************************************************
*
* This model is subject to change without notice. Texas Instruments
* Incorporated is not responsible for updating this model.
*
*****************************************************************************
*
** Released by: WEBENCH Design Center, Texas Instruments Inc.
* Part: LMZM33602
* Date: 27OCT2017
* Model Type: TRANSIENT
* Simulator: PSPICE
* Simulator Version: 16.2.0.p001
* EVM Order Number: LMZM33602EVM
* EVM Users Guide: SNVU565-August 2017
* Datasheet: SNVSAO6 - SEPTEMBER 2017
* Topologies Supported: Buck,Inverting Buck Boost
*
* Model Version: Final 1.00
*
*****************************************************************************
*
* Updates:
*
* Final 1.00
* Release to Web.
*
*****************************************************************************
*
* Model Usage Notes:
*
* 1. The following features have been modeled
*      a. Frequency foldback during soft-start
*      b. Current foldback
*      c. Current limit, Hiccup
*      d. IBB compatible
*      e. PGOOD functionality with Deglitch filter
* 2. The operating quiescent current and thermal shutdown characteristics have not been modeled.
*
*****************************************************************************
.SUBCKT LMZM33602_TRANS AGND DNC DNC_1 EN_SYNC FB PGND PGND_1 PGND_2 PGND_3
+  PGOOD RT SW SW_1 SW_2 VIN VOUT VOUT_1 VOUT_2  PARAMS: MODE=0 IPEAK=5.5 IVALLEY_TH=3.8 ILNEG_TH=2
C_C1         DNC_1 PGND_1  2.2u
L_L1         SW VOUT  6.8uH
C_C2         DNC SW  0.1u IC={mode*5}
E_U1_ABM1         U1_FPWMFORCE 0 VALUE { If(V(U1_VREF)<0.98,0,1)    }
R_U1_R5         U1_N16790946 AGND  1m
R_U1_R6         U1_N16790946 AGND  1m
E_U1_E1         U1_FBI 0 FB PGND 1
C_U1_U1_C2         0 U1_U1_N16765634  13.5p
C_U1_U1_C1         0 U1_COMP  1p
R_U1_U1_R1         U1_FBI U1_U1_N16765634  25k
G_U1_U1_ABM2I1         0 U1_COMP VALUE { LIMIT(IF(V(U1_VREF)>0.98, (V(U1_VREF)
+  - V(U1_U1_N16765634))*14u, (V(U1_VREF) - V(U1_U1_N16765634))*7u),-2.5u,2u)
+  }
V_U1_U1_V6         U1_U1_N16765450 0 1.8
E_U1_U1_ABM2         U1_I_FOLDBACK 0 VALUE { if( V(U1_FPWMFORCE)< 0.5,
+ V(U1_U1_N16765598) ,0)   }
C_U1_U1_C3         0 U1_FBI  100f
E_U1_U1_ABM3         U1_PFM 0 VALUE { IF(V(U1_COMP)<0.25,1,0)    }
D_U1_U1_D10         U1_COMP U1_U1_N16765450 D_D
X_U1_U1_H1    U1_U1_N16765504 U1_COMP U1_U1_N16765466 0
+  ERROR_AMPLIFIER_U1_U1_H1
V_U1_U1_V9         U1_U1_N167658641 0 0.25
X_U1_U1_S1    U1_HICCUP 0 U1_COMP 0 ERROR_AMPLIFIER_U1_U1_S1
D_U1_U1_D9         U1_U1_N167658641 U1_U1_N16765504 D_D
E_U1_U1_ABM1         U1_U1_N16765598 0 VALUE { MAX ( V(U1_U1_N16765466) , 0 )
+   }
C_U1_C4         0 U1_N16789886  50p
V_U1_U2_V1         U1_U2_N16758309 0 1.01
X_U1_U2_F1    U1_U2_N16758379 U1_U2_N16758343 U1_U2_SS_INT 0
+  SOFT_START_U1_U2_F1
G_U1_U2_ABMII1         U1_U2_N16758309 U1_U2_SS_INT VALUE { IF(V(U1_U2_DISCH) >
+  0.5,0,3u)    }
E_U1_U2_ABM7         U1_U2_VREF_FEED 0 VALUE { LIMIT(V(U1_U2_N16758447) ,20m,0)
+     }
R_U1_U2_R2         U1_U2_N16758343 U1_U2_N16758297  1000k
E_U1_U2_ABM5         U1_U2_N16758407 0 VALUE { IF(V(U1_U2_VREF_INT)
+  >0.9,V(U1_U2_VREF_FEED),0)    }
C_U1_U2_C3         0 U1_U2_N16758297  0.4n
E_U1_U2_E2         U1_U2_N16758441 0 VIN 0 0.5
R_U1_U2_R1         0 U1_U2_N16758447  1k
E_U1_U2_E1         U1_VREF U1_U2_N16758407 U1_U2_VREF_INT 0 1
C_U1_U2_C2         U1_U2_N16758447 U1_U2_N16758441  0.1n
X_U1_U2_S1    U1_U2_DISCH 0 U1_U2_SS_INT 0 SOFT_START_U1_U2_S1
X_U1_U2_U3         U1_SDWN U1_HICCUP U1_U2_DISCH OR2_BASIC_GEN PARAMS: VDD=1
+  VSS=0 VTHRESH=500E-3
E_U1_U2_ABM1         U1_U2_VREF_INT 0 VALUE { MIN( V(U1_U2_SS_INT) , 1)    }
E_U1_U2_ABM6         U1_U2_N16758379 0 VALUE { IF( V(U1_U2_DISCH) < 0.5,1, 0)
+   }
D_U1_U2_D62         U1_U2_SS_INT U1_U2_N16758309 D_D1
C_U1_U2_C1         U1_U2_SS_INT 0  18n IC={mode}
V_U1_U7_V9         U1_U7_N16763491 0 3.299
X_U1_U7_U617         U1_U7_EN_OK U1_U7_ENOK_B INV_BASIC_GEN PARAMS: VDD=1 VSS=0
+  VTHRESH=500E-3
X_U1_U7_U614         EN_SYNC U1_U7_N16763401 U1_U7_N16763395 U1_U7_N16763457
+  COMPHYS_BASIC_GEN PARAMS: VDD=1 VSS=0 VTHRESH=0.5
E_U1_U7_ABM3         U1_VCC_I 0 VALUE { IF(V(VIN)>4.1,4.1,V(VIN))    }
V_U1_U7_V8         U1_U7_N16763485 0 0.4
V_U1_U7_V12         U1_U7_N16763453 0
+PULSE {1-MODE} 0 1u 1n 1n 1 2
V_U1_U7_V6         U1_U7_N16763395 0 0.4
V_U1_U7_V7         U1_U7_N16763401 0 1.5499
V_U1_U7_V4         U1_U7_N16763349 0 3.599
X_U1_U7_U618         U1_U7_VCC_OK U1_U7_VCCOK_B INV_BASIC_GEN PARAMS: VDD=1
+  VSS=0 VTHRESH=500E-3
X_U1_U7_U623         U1_U7_N16763457 U1_U7_EN_OK BUF_DELAY_BASIC_GEN PARAMS:
+  VDD=1 VSS=0 VTHRESH=0.5 DELAY=0.7m
X_U1_U7_U613         VIN U1_U7_N16763349 U1_U7_N16763343 U1_U7_VIN_OK
+  COMPHYS_BASIC_GEN PARAMS: VDD=1 VSS=0 VTHRESH=0.5
X_U1_U7_U616         U1_U7_VIN_OK U1_VINOK_B INV_BASIC_GEN PARAMS: VDD=1 VSS=0
+  VTHRESH=500E-3
X_U1_U7_U615         U1_VCC_I U1_U7_N16763491 U1_U7_N16763485 U1_U7_VCC_OK
+  COMPHYS_BASIC_GEN PARAMS: VDD=1 VSS=0 VTHRESH=0.5
X_U1_U7_U622         U1_VINOK_B U1_U7_ENOK_B U1_U7_VCCOK_B U1_U7_N16763453
+  U1_SDWN OR4_BASIC_GEN PARAMS: VDD=1 VSS=0 VTHRESH=500E-3
E_U1_U7_E4         DNC_1 PGND U1_VCC_I 0 1
V_U1_U7_V5         U1_U7_N16763343 0 0.3
C_U1_C6         0 U1_COMP  0.5p
X_U1_U5_U608         U1_U5_N16187 U1_U5_N16177 U1_U5_N16335 AND2_BASIC_GEN
+  PARAMS: VDD=1 VSS=0 VTHRESH=500E-3
X_U1_U5_U609         U1_U5_N16265 U1_U5_N16273 U1_U5_N16239 COMP_BASIC_GEN
+  PARAMS: VDD=1 VSS=0 VTHRESH=0.5
C_U1_U5_C6         0 U1_U5_N16265  14.8n IC=0
C_U1_U5_C5         0 U1_U5_N16187  1n
X_U1_U5_U2_U620         U1_U5_N16541 U1_U5_U2_N00780 U1_U5_U2_N00140
+  OR2_BASIC_GEN PARAMS: VDD=1 VSS=0 VTHRESH=500E-3
X_U1_U5_U2_U618         U1_U5_U2_N00220 U1_U5_U2_N02470 U1_U5_N16587
+  AND2_BASIC_GEN PARAMS: VDD=1 VSS=0 VTHRESH=500E-3
D_U1_U5_U2_D1         U1_U5_N16541 U1_U5_U2_N00780 D_D1
X_U1_U5_U2_U621         U1_U5_U2_N00140 U1_U5_U2_N00220 INV_BASIC_GEN PARAMS:
+  VDD=1 VSS=0 VTHRESH=500E-3
R_U1_U5_U2_R1         U1_U5_N16541 U1_U5_U2_N00780  144.3001443
X_U1_U5_U2_U607         U1_U5_U2_N00140 U1_U5_U2_N03610 INV_DELAY_BASIC_GEN
+  PARAMS: VDD=1 VSS=0 VTHRESH=0.5 DELAY=50n
C_U1_U5_U2_C1         0 U1_U5_U2_N00780  1n
X_U1_U5_U2_U608         U1_U5_U2_N03610 U1_U5_U2_N02470 INV_DELAY_BASIC_GEN
+  PARAMS: VDD=1 VSS=0 VTHRESH=0.5 DELAY=50n
X_U1_U5_U610         U1_U5_N16391 U1_U5_N16611 INV_DELAY_BASIC_GEN PARAMS:
+  VDD=1 VSS=0 VTHRESH=0.5 DELAY=5u
R_U1_U5_R5         U1_U5_N16391 U1_U5_N16381  1
X_U1_U5_U612         U1_U5_N16445 U1_U5_N16453 U1_U5_N16381 COMP_BASIC_GEN
+  PARAMS: VDD=1 VSS=0 VTHRESH=0.5
V_U1_U5_V4         U1_U5_N16453 0 1
E_U1_U5_ABM8         U1_U5_N16143 0 VALUE { IF(V(U1_COMP) > 1.8,1,0)    }
C_U1_U5_C7         0 U1_U5_N16445  10u IC=0
X_U1_U5_U611         U1_U5_N16611 U1_U5_H_END INV_DELAY_BASIC_GEN PARAMS: VDD=1
+  VSS=0 VTHRESH=0.5 DELAY=5u
G_U1_U5_G4         0 U1_U5_N16445 U1_HICCUP 0 1m
G_U1_U5_G3         0 U1_U5_N16265 U1_U5_N16109 0 1
X_U1_U5_U30         U1_U5_N16239 U1_U5_H_END U1_HICCUP U1_U5_HICCUP_N
+  SRLATCHRHP_BASIC_GEN PARAMS: VDD=1 VSS=0 VTHRESH=0.5
X_U1_U5_S4    U1_U5_H_END 0 U1_U5_N16445 0 HICCUP1_U1_U5_S4
X_U1_U5_U616         U1_U5_N16143 U1_CLK U1_U5_HICCUP_N U1_U5_N16109
+  AND3_BASIC_GEN PARAMS: VDD=1 VSS=0 VTHRESH=500E-3
R_U1_U5_R8         U1_U5_N16187 U1_HICCUP  1
X_U1_U5_U607         U1_U5_N16187 U1_U5_N16177 INV_DELAY_BASIC_GEN PARAMS:
+  VDD=1 VSS=0 VTHRESH=0.5 DELAY=10u
E_U1_U5_ABM9         U1_U5_N16541 0 VALUE { {IF(V(U1_COMP) > 1,1,0)}    }
V_U1_U5_V2         U1_U5_N16273 0 64
C_U1_U5_C8         0 U1_U5_N16391  1n
X_U1_U5_U615         U1_U5_N16587 U1_U5_N16335 U1_U5_N16351 OR2_BASIC_GEN
+  PARAMS: VDD=1 VSS=0 VTHRESH=500E-3
X_U1_U5_S3    U1_U5_N16351 0 U1_U5_N16265 0 HICCUP1_U1_U5_S3
X_U1_U4_H1    VIN U1_U4_N140778 U1_U4_N140916 0 Driver_mod_U1_U4_H1
D_U1_U4_D73         U1_U4_N141178 U1_PH1 D_D1
D_U1_U4_D70         U1_U4_N140936 DNC D_D1
E_U1_U4_E2         U1_U4_N140586 0 U1_U4_N140568 0 1
C_U1_U4_C178         0 U1_U4_N140568  1n
D_U1_U4_D69         U1_U4_N140700 U1_PH1 D_D1
E_U1_U4_E_test         U1_U4_BOOT_SW_ON 0 VALUE {
+  IF((V(U1_U4_BOOT_SW_ON_INT)>0.5 & V(U1_SDWN) < 0.5),1,0)    }
R_U1_U4_R11         U1_PH2 U1_U4_N141290  72.15 TC=0,0
C_U1_U4_C12         0 U1_U4_L_ISWH  1n
X_U1_U4_U643         U1_U4_LDRV_INT U1_U4_LDRV_INTB U1_PH2 U1_U4_N141426
+  U1_U4_ZCDLRES 0 dffsr_rhpbasic_gen PARAMS: VDD=1 VSS=0 VTHRESH=500E-3
X_U1_U4_U665         U1_FPWMFORCE U1_PH1 U1_U4_N141714 AND2_BASIC_GEN PARAMS:
+  VDD=1 VSS=0 VTHRESH=500E-3
X_U1_U4_S1    U1_HDRV SW U1_U4_N140778 SW Driver_mod_U1_U4_S1
X_U1_U4_U666         U1_U4_N141728 U1_U4_N141714 U1_U4_N140520 AND2_BASIC_GEN
+  PARAMS: VDD=1 VSS=0 VTHRESH=500E-3
C_U1_U4_C11         0 U1_ISWH  1n
X_U1_U4_U644         U1_U4_N141488 U1_U4_N141460 U1_U4_ZCDLRES OR2_BASIC_GEN
+  PARAMS: VDD=1 VSS=0 VTHRESH=500E-3
D_U1_U4_D65         U1_U4_N140910 SW D_D1
X_U1_U4_U651         U1_SDWN U1_U4_N140988 INV_BASIC_GEN PARAMS: VDD=1 VSS=0
+  VTHRESH=500E-3
R_U1_U4_R280         0 U1_U4_ZCDTHRESH  1e9
E_U1_U4_E1         U1_U4_N140544 0 U1_U4_ZCDTHRESH 0 -1
X_U1_U4_U617         U1_U4_N140544 U1_U4_L_ISWH U1_U4_ZCD COMP_BASIC_GEN
+  PARAMS: VDD=1 VSS=0 VTHRESH=0.5
R_U1_U4_R12         U1_PH1 U1_U4_N140700  28.86 TC=0,0
X_U1_U4_U663         U1_U4_N141650 U1_U4_N141664 INV_DELAY_BASIC_GEN PARAMS:
+  VDD=1 VSS=0 VTHRESH=0.5 DELAY=40n
X_U1_U4_U650         U1_HICCUP U1_U4_N140796 INV_BASIC_GEN PARAMS: VDD=1 VSS=0
+  VTHRESH=500E-3
X_U1_U4_U648         U1_HDRV_INT U1_U4_N140760 INV_BASIC_GEN PARAMS: VDD=1
+  VSS=0 VTHRESH=500E-3
X_U1_U4_U652         U1_U4_LDRV_INT U1_U4_N140796 U1_U4_N140988 U1_LDRV
+  AND3_BASIC_GEN PARAMS: VDD=1 VSS=0 VTHRESH=500E-3
C_U1_U4_C14         0 U1_U4_N141178  1n  TC=0,0
X_U1_U4_S35    U1_U4_BOOT_SW_ON 0 U1_U4_N140936 U1_VCC_I Driver_mod_U1_U4_S35
X_U1_U4_S2    U1_LDRV 0 SW U1_U4_N140910 Driver_mod_U1_U4_S2
D_U1_U4_D72         U1_U4_N141294 U1_U4_N140568 D_Dton
R_U1_U4_R277         U1_U4_N140568 U1_U4_N141294  144.3
D_U1_U4_D9         U1_U4_VLOWER U1_U4_ZCDTHRESH D_D
X_U1_U4_U645         U1_PH2 U1_U4_N141488 INV_BASIC_GEN PARAMS: VDD=1 VSS=0
+  VTHRESH=500E-3
X_U1_U4_U611         U1_U4_N141290 U1_PH2 U1_L_BLNCK AND2_BASIC_GEN PARAMS:
+  VDD=1 VSS=0 VTHRESH=500E-3
R_U1_U4_R15         U1_PH1 U1_U4_N141178  21.65 TC=0,0
X_U1_U4_U615         U1_U4_ZCD U1_L_BLNCK U1_U4_N141460 AND2_BASIC_GEN PARAMS:
+  VDD=1 VSS=0 VTHRESH=500E-3
G_U1_U4_ABMII1         U1_U4_N141752 U1_U4_ZCDTHRESH VALUE {
+  if(V(U1_U4_N140520) >0.5, 350n,0)    }
G_U1_U4_ABMII2         U1_U4_ZCDTHRESH 0 VALUE { if(V(U1_U4_N140526) >0.5,
+  350n,0)    }
D_U1_U4_D10         U1_U4_ZCDTHRESH U1_U4_VUPPER D_D
X_U1_U4_U656         U1_L_BLNCK U1_U4_N138612 U1_U4_N141294 AND2_BASIC_GEN
+  PARAMS: VDD=1 VSS=0 VTHRESH=500E-3
X_U1_U4_H2    U1_U4_N140910 PGND U1_U4_N140904 0 Driver_mod_U1_U4_H2
E_U1_U4_ABM172         U1_U4_N140660 0 VALUE { IF(((V(DNC) - V(SW)) > 2.8), 0 ,
+  1)    }
X_U1_U4_U662         U1_U4_N141664 U1_U4_N141650 U1_U4_N140526 AND2_BASIC_GEN
+  PARAMS: VDD=1 VSS=0 VTHRESH=500E-3
X_U1_U4_S5    U1_U4_N140760 0 U1_HDRV PGND Driver_mod_U1_U4_S5
D_U1_U4_D68         U1_U4_N141290 U1_PH2 D_D1
X_U1_U4_U610         U1_U4_N141178 U1_PH1 U1_HDRV_INT AND2_BASIC_GEN PARAMS:
+  VDD=1 VSS=0 VTHRESH=500E-3
R_U1_U4_R247         U1_U4_L_ISWH U1_U4_N140904  1
C_U1_U4_C8         0 U1_U4_N141290  1n  TC=0,0
X_U1_U4_S4    U1_HDRV_INT 0 DNC U1_HDRV Driver_mod_U1_U4_S4
V_U1_U4_V9         U1_U4_N141752 0 1.2
X_U1_U4_U621         U1_U4_N162176 U1_U4_L_ISWH U1_U4_N138612 COMP_BASIC_GEN
+  PARAMS: VDD=1 VSS=0 VTHRESH=0.5
C_U1_U4_C1         0 U1_U4_ZCDTHRESH  2p
D_U1_U4_D64         SW U1_U4_N140778 D_D1
X_U1_U4_U667         U1_U4_N141714 U1_U4_N141728 INV_DELAY_BASIC_GEN PARAMS:
+  VDD=1 VSS=0 VTHRESH=0.5 DELAY=40n
V_U1_U4_V7         U1_U4_VUPPER 0 {ILNEG_TH}
R_U1_U4_R14         U1_U4_N140660 U1_U4_BOOT_UVLO  1 TC=0,0
X_U1_U4_U646         U1_U4_BOOT_UVLO U1_LDRV U1_U4_BOOT_SW_ON_INT OR2_BASIC_GEN
+  PARAMS: VDD=1 VSS=0 VTHRESH=500E-3
V_U1_U4_V4         U1_U4_N162176 0 {IVALLEY_TH}
X_U1_U4_U671         U1_FPWMFORCE U1_U4_N140600 INV_BASIC_GEN PARAMS: VDD=1
+  VSS=0 VTHRESH=500E-3
C_U1_U4_C9         0 U1_U4_N140700  1n  TC=0,0
R_U1_U4_R278         U1_LOK U1_U4_N140586  22
V_U1_U4_V5         U1_U4_N141426 0 1
C_U1_U4_C13         0 U1_U4_BOOT_UVLO  1n  TC=0,0
R_U1_U4_R246         U1_ISWH U1_U4_N140916  1
R_U1_U4_R245         0 DNC  100MEG
V_U1_U4_V8         U1_U4_VLOWER 0 .04
X_U1_U4_U612         U1_U4_N140700 U1_PH1 U1_H_BLNCK AND2_BASIC_GEN PARAMS:
+  VDD=1 VSS=0 VTHRESH=500E-3
X_U1_U4_U675         U1_U4_N140600 U1_PH1 U1_U4_N141650 AND2_BASIC_GEN PARAMS:
+  VDD=1 VSS=0 VTHRESH=500E-3
C_U1_U4_C179         U1_LOK 0  1n
X_U1_U6_U629         U1_CLK U1_U6_N16779278 U1_U6_PH1_1 U1_U6_N16779216
+  SRLATCHRHP_BASIC_GEN PARAMS: VDD=1 VSS=0 VTHRESH=0.5
X_U1_U6_U610         U1_U6_N16780920 U1_U6_N16781026 U1_U6_PG0 COMP_BASIC_GEN
+  PARAMS: VDD=1 VSS=0 VTHRESH=0.5
E_U1_U6_ABM2         U1_U6_N16779190 0 VALUE { V(U1_U6_ISWF)    }
R_U1_U6_R276         U1_U6_N16779141 U1_U6_N16779148  86.58
E_U1_U6_ABM3         U1_U6_VREFTH_HIGH 0 VALUE { (V(U1_U6_N16780843)*1.06)    }
C_U1_U6_C8         0 U1_U6_N16781230  1u IC=0
V_U1_U6_VIN         U1_U6_N16780843 0 1
X_U1_U6_U834         U1_SDWN U1_U6_N16779307 U1_U6_N16779170 U1_U6_PREBIAS
+  SRLATCHRHP_BASIC_GEN PARAMS: VDD=1 VSS=0 VTHRESH=0.5
C_U1_U6_C10         0 U1_U6_PG0  1n IC=0
X_U1_U6_U826         U1_U6_PH1_1 U1_U6_N16779228 INV_DELAY_BASIC_GEN PARAMS:
+  VDD=1 VSS=0 VTHRESH=0.5 DELAY=15n
E_U1_U6_E1         U1_U6_N16779710 0 U1_PH1 0 1
X_U1_U6_U619         U1_U6_VREFTH_HIGH U1_FBI U1_U6_N16781114 U1_U6_N16780905
+  COMPHYS_BASIC_GEN PARAMS: VDD=1 VSS=0 VTHRESH=0.5
G_U1_U6_G4         0 U1_U6_N16781230 U1_U6_ANDOUT1 0 1
E_U1_U6_ABM5         U1_U6_VREFTH_LOW 0 VALUE { (V(U1_U6_N16780879)*0.94)    }
X_U1_U6_U630         U1_U6_N16779157 U1_H_BLNCK U1_U6_N16779347 AND2_BASIC_GEN
+  PARAMS: VDD=1 VSS=0 VTHRESH=500E-3
V_U1_U6_VIN1         U1_U6_N16780879 0 1
R_U1_U6_R3         0 U1_U6_N16779216  1Meg TC=0,0
D_U1_U6_D11         U1_U6_TMOD U1_U6_N16779710 D_Dton
V_U1_U6_V9         U1_U6_N16781114 0 0.01
X_U1_U6_S5    U1_U6_N16781223 0 U1_U6_N16781230 0 GmIphase_U1_U6_S5
X_U1_U6_U827         U1_U6_N16779228 U1_U6_PH1_1 U1_U6_N16779141 AND2_BASIC_GEN
+  PARAMS: VDD=1 VSS=0 VTHRESH=500E-3
R_U1_U6_R278         U1_U6_N16779710 U1_U6_TMOD  7.215k
V_U1_U6_V12         U1_U6_N16781157 0 0.01
X_U1_U6_U830         U1_U6_N16780905 U1_U6_N16780869 U1_U6_N16780830
+  AND2_BASIC_GEN PARAMS: VDD=1 VSS=0 VTHRESH=500E-3
X_U1_U6_U612         U1_VREF U1_FBI U1_U6_N16779307 COMP_BASIC_GEN PARAMS:
+  VDD=1 VSS=0 VTHRESH=0.5
C_U1_U6_C179         0 U1_U6_TMOD  1n
X_U1_U6_U620         U1_FBI U1_U6_VREFTH_LOW U1_U6_N16781157 U1_U6_N16780869
+  COMPHYS_BASIC_GEN PARAMS: VDD=1 VSS=0 VTHRESH=0.5
C_U1_U6_C9         0 U1_U6_N16780920  1u IC=0
E_U1_U6_ABM1         U1_U6_ICMD 0 VALUE { LIMIT ( (( V(U1_COMP)-0.25)*6.7)  -
+  V(U1_ISLOPE), IPEAK, 0)    }
X_U1_U6_U829         U1_U6_PH2_1 U1_U6_PREBIAS U1_PH2 AND2_BASIC_GEN PARAMS:
+  VDD=1 VSS=0 VTHRESH=500E-3
R_U1_U6_R4         U1_U6_N16779170 0  1Meg TC=0,0
E_U1_U6_ABM154         U1_U6_ANDOUT1 0 VALUE { IF(V(U1_U6_N16780830)>0.5,1,0)
+   }
X_U1_U6_U837         U1_U6_PG1 U1_U6_PG0 U1_U6_PG10 N16780734
+  SRLATCHRHP_BASIC_GEN PARAMS: VDD=1 VSS=0 VTHRESH=0.5
D_U1_U6_D10         U1_U6_N16779141 U1_U6_N16779148 D_Dton
E_U1_U6_ABM155         U1_U6_ANDOUT0 0 VALUE { IF(V(U1_U6_N16780830)<0.5,1,0)
+   }
G_U1_U6_G5         0 U1_U6_N16780920 U1_U6_ANDOUT0 0 1
C_U1_U6_C177         0 U1_U6_N16779148  1n
X_U1_U6_U5         U1_U6_N16779190 U1_U6_ICMD U1_U6_N16779154 COMP_BASIC_GEN
+  PARAMS: VDD=1 VSS=0 VTHRESH=0.5
X_U1_U6_S6    U1_U6_N16780982 0 U1_U6_N16780920 0 GmIphase_U1_U6_S6
D_U1_U6_D13         U1_U6_N16780742 PGOOD D_Dton
R_U1_U6_R277         U1_U6_N16779154 U1_U6_N16779157  1
E_U1_U6_ABM153         U1_U6_N16779326 0 VALUE {
+  IF(V(U1_PFM)>0.5,V(U1_U6_TMOD),0)    }
X_U1_U6_U831         U1_U6_ANDOUT1 U1_U6_N16781223 INV_BASIC_GEN PARAMS: VDD=1
+  VSS=0 VTHRESH=500E-3
X_U1_U6_U825         U1_U6_N16779141 U1_U6_N16779148 U1_U6_PH1_1 U1_PH1
+  OR3_BASIC_GEN PARAMS: VDD=1 VSS=0 VTHRESH=500E-3
X_U1_U6_U835         U1_U6_N16779326 U1_U6_N16779347 U1_U6_N16779278
+  OR2_BASIC_GEN PARAMS: VDD=1 VSS=0 VTHRESH=500E-3
I_U1_U6_I2         PGOOD U1_U6_N16780742 DC 1mAdc
E_U1_U6_ABM152         U1_U6_ISWF 0 VALUE { {IF(V(U1_HDRV_INT) > 0.5,
+ V(U1_ISWH),0)}   }
V_U1_U6_V2         U1_U6_N16781248 0 150
V_U1_U6_V3         U1_U6_N16781026 0 18
C_U1_U6_C178         0 U1_U6_N16779157  1n
X_U1_U6_S7    U1_U6_PG10 0 U1_U6_N16780742 0 GmIphase_U1_U6_S7
X_U1_U6_U832         U1_U6_ANDOUT0 U1_U6_N16780982 INV_BASIC_GEN PARAMS: VDD=1
+  VSS=0 VTHRESH=500E-3
X_U1_U6_U609         U1_U6_N16781230 U1_U6_N16781248 U1_U6_PG1 COMP_BASIC_GEN
+  PARAMS: VDD=1 VSS=0 VTHRESH=0.5
X_U1_U6_U828         U1_PH1 U1_U6_PH2_1 INV_BASIC_GEN PARAMS: VDD=1 VSS=0
+  VTHRESH=500E-3
C_U1_U6_C7         0 U1_U6_PG1  1n IC=0
E_U1_U3_ABM18         U1_U3_CLK_CURRENT 0 VALUE { IF(V(U1_U3_SLOPE_CH) >0.5,(
+  V(U1_U3_N16895037) - V(U1_U3_N16895053))/30,
+  (V(U1_U3_N16895037) - V(U1_U3_N16895053)))   }
X_U1_U3_U157         U1_I_FOLDBACK U1_U3_N16874354 U1_U3_ADDRAMP COMP_BASIC_GEN
+  PARAMS: VDD=1 VSS=0 VTHRESH=0.5
C_U1_U3_C79         U1_U3_RAMP 0  10p IC=0
R_U1_U3_R6         U1_U3_N16869766 U1_U3_RAMPMUL  1m
I_U1_U3_I1         U1_U3_N16887592 RT DC 10udc
R_U1_U3_R7         U1_I_FOLDBACK U1_U3_FOLD_FILT  100k TC=0,0
X_U1_U3_U143         U1_U3_N16869535 U1_U3_CLK_SYNC one_shot PARAMS:  T=30
C_U1_U3_C1         U1_U3_N16756738 U1_U3_N16756744  1n
C_U1_U3_C150         U1_U3_RAMPMUL 0  10u
D_U1_U3_D64         RT U1_U3_N16887592 D_D1
X_U1_U3_U145         U1_U3_N16845235 U1_U3_N16845117 U1_CLK AND2_BASIC_GEN
+  PARAMS: VDD=1 VSS=0 VTHRESH=500E-3
V_U1_U3_V8         U1_U3_N168794300 0 1
E_U1_U3_E6         U1_U3_N16895034 0 RT PGND 1
E_U1_U3_ABM12         U1_U3_SYNC_ISLOPE 0 VALUE { if ( V(U1_U3_N16870601)<0.5,
+
+ 0
+ , V(U1_U3_INT_ISLOPE)/(1m+V(U1_U3_RAMPMUL)) )  }
C_U1_U3_C149         U1_U3_CLK_INT_DISABLE 0  1n IC=0 TC=0,0
X_U1_U3_U677         U1_U3_SYNC_VINB U1_U3_CLK_INT_DISABLE U1_U3_SYNC_SDWNB
+  U1_U3_CLK_SYNC_EN AND3_BASIC_GEN PARAMS: VDD=1 VSS=0 VTHRESH=500E-3
V_U1_U3_V48         U1_U3_N16887592 0 5Vdc
D_U1_U3_D62         0 U1_U3_N16756744 D_D1
G_U1_U3_ABM2I5         U1_U3_N40138 U1_U3_N16845134 VALUE {
+  if(V(U1_U3_CLK_SYNC_EN)<0.5,V(U1_U3_CLK_CURRENT),4u)    }
X_U1_U3_U1         U1_U3_N16868915 VIN U1_U3_N168794300 U1_U3_SYNC_VINB
+  COMPHYS2_BASIC_GEN PARAMS: VDD=1 VSS=0 VTHRESH=0.5 T=10
X_U1_U3_U131         U1_U3_RAMP U1_U3_N16845023 U1_U3_SLOPE_CH COMP_BASIC_GEN
+  PARAMS: VDD=1 VSS=0 VTHRESH=0.5
X_U1_U3_U138         U1_LOK U1_HDRV U1_U3_N16845062 U1_U3_N16845571
+  SRLATCHRHP_BASIC_GEN PARAMS: VDD=1 VSS=0 VTHRESH=0.5
E_U1_U3_ABM16         U1_U3_N16895053 0 VALUE { V(U1_I_FOLDBACK)*20    }
R_U1_U3_R1         U1_U3_N16845030 U1_CLK  15 TC=0,0
D_U1_U3_D14         0 U1_U3_N16845134 D_D1
R_U1_U3_R2         U1_U3_N16756744 0  1k
V_U1_U3_V7         U1_U3_N16868915 0 21
C_U1_U3_C148         0 U1_U3_N16845030  1n  TC=0,0
E_U1_U3_ABM14         U1_U3_SYNC_SDWNB 0 VALUE { IF(V(U1_VREF)>0.98*1,1,0)    }
X_U1_U3_U140         U1_U3_N16845062 U1_U3_SLOPE_CH U1_U3_N16845113
+  AND2_BASIC_GEN PARAMS: VDD=1 VSS=0 VTHRESH=500E-3
X_U1_U3_U153         U1_U3_N16869535 U1_U3_CLK_SAM one_shot PARAMS:  T=10
D_U1_U3_D11         U1_U3_N16845134 U1_U3_N40138 D_D1
R_U1_U3_R5         U1_U3_N16775751 U1_U3_CLK_INT_DISABLE  8k TC=0,0
E_U1_U3_ABM6         U1_U3_SYNC_INT 0 VALUE { If(V(U1_U3_SYNC_INT) <0.5,
+  If(V(U1_U3_N16756744)>2.79, 1, 0), If(V(U1_U3_N16756744)>0.1, 1, 0))     }
X_U1_U3_U156         U1_U3_SYNC_INT U1_U3_N16869535 BUF_DELAY_BASIC_GEN PARAMS:
+  VDD=1 VSS=0 VTHRESH=0.5 DELAY=100n
E_U1_U3_ABM13         U1_U3_N16874354 0 VALUE { if(V(U1_U3_FOLD_FILT)> 0.05u,
+  V(U1_U3_FOLD_FILT)*1.9,1)    }
G_U1_U3_ABM2I2         U1_U3_N40138 U1_U3_RAMP VALUE { if(V(U1_U3_ADDRAMP) >0.5
+  & V(U1_PH2)<0.5, 4u,0)    }
D_U1_U3_D15         U1_U3_N16845134 U1_U3_RAMP D_D1
X_U1_U3_U154         U1_U3_CLK_SYNC_EN U1_U3_N16870601 BUF_DELAY_BASIC_GEN
+  PARAMS: VDD=1 VSS=0 VTHRESH=0.5 DELAY=2u
V_U1_U3_V45         U1_U3_N40138 0 10
X_U1_U3_U146         U1_HICCUP U1_SDWN U1_U3_N16845117 NOR2_BASIC_GEN PARAMS:
+  VDD=1 VSS=0 VTHRESH=500E-3
E_U1_U3_E2         U1_U3_N16870068 0 U1_U3_RAMP 0 1
R_U1_U3_R4         0 U1_U3_N16845571  1Meg TC=0,0
C_U1_U3_C151         U1_U3_FOLD_FILT 0  1n  TC=0,0
V_U1_U3_V47         U1_U3_N16845023 0 1
X_U1_U3_S27    U1_U3_CLK_SAM 0 U1_U3_N16870068 U1_U3_N16869766
+  Oscillator_U1_U3_S27
X_U1_U3_S26    U1_U3_DISCHARGE 0 U1_U3_RAMP 0 Oscillator_U1_U3_S26
E_U1_U3_E3         U1_U3_N16756738 0 EN_SYNC PGND 1
E_U1_U3_E4         U1_U3_N16775751 0 U1_U3_CLK_SYNC 0 1
X_U1_U3_U142         U1_U3_N16845113 U1_U3_CLK_SYNC U1_U3_CLK_SYNC_EN
+  U1_U3_N16845235 MUX2_BASIC_GEN PARAMS: VDD=1 VSS=0 VTHRESH=0.5
D_U1_U3_D1         U1_U3_N16775751 U1_U3_CLK_INT_DISABLE D_D1
E_U1_U3_ABM22         U1_U3_N16895037 0 VALUE { {IF(V(U1_SDWN)
+  <0.5,IF(V(RT)<3,((V(U1_VREF)*((402u/((100*V(U1_U3_N16895034))+0.6))-0.5u))+0.5u),3.5u*V(U1_VREF)+0.5u),0)}
+     }
X_U1_U3_U155         U1_U3_INT_ISLOPE U1_U3_SYNC_ISLOPE U1_U3_CLK_SYNC_EN
+  U1_ISLOPE MUX2_BASIC_GEN PARAMS: VDD=1 VSS=0 VTHRESH=0.5
E_U1_U3_ABM7         U1_U3_INT_ISLOPE 0 VALUE { V(U1_U3_RAMP)*6.7*0.308    }
X_U1_U3_U137         U1_VINOK_B U1_U3_N16845030 U1_U3_DISCHARGE OR2_BASIC_GEN
+  PARAMS: VDD=1 VSS=0 VTHRESH=500E-3
R_U1_R4         U1_N16789886 U1_COMP  375k
C_C3         VIN PGND  0.1u
.IC         V(U1_COMP )=0
.ENDS LMZM33602_TRANS
*$
.subckt ERROR_AMPLIFIER_U1_U1_H1 1 2 3 4
H_U1_U1_H1         3 4 VH_U1_U1_H1 1
VH_U1_U1_H1         1 2 0V
.ends ERROR_AMPLIFIER_U1_U1_H1
*$
.subckt ERROR_AMPLIFIER_U1_U1_S1 1 2 3 4
S_U1_U1_S1         3 4 1 2 _U1_U1_S1
RS_U1_U1_S1         1 2 1G
.MODEL         _U1_U1_S1 VSWITCH Roff=1.409e9 Ron=3k Voff=0.25V Von=0.75V
.ends ERROR_AMPLIFIER_U1_U1_S1
*$
.subckt SOFT_START_U1_U2_F1 1 2 3 4
F_U1_U2_F1         3 4 VF_U1_U2_F1 1.2
VF_U1_U2_F1         1 2 0V
.ends SOFT_START_U1_U2_F1
*$
.subckt SOFT_START_U1_U2_S1 1 2 3 4
S_U1_U2_S1         3 4 1 2 _U1_U2_S1
RS_U1_U2_S1         1 2 1G
.MODEL         _U1_U2_S1 VSWITCH Roff=1e9 Ron=3k Voff=0.2 Von=0.5
.ends SOFT_START_U1_U2_S1
*$
.subckt HICCUP1_U1_U5_S4 1 2 3 4
S_U1_U5_S4         3 4 1 2 _U1_U5_S4
RS_U1_U5_S4         1 2 1G
.MODEL         _U1_U5_S4 VSWITCH Roff=1e6 Ron=1m Voff=0.25 Von=0.8
.ends HICCUP1_U1_U5_S4
*$
.subckt HICCUP1_U1_U5_S3 1 2 3 4
S_U1_U5_S3         3 4 1 2 _U1_U5_S3
RS_U1_U5_S3         1 2 1G
.MODEL         _U1_U5_S3 VSWITCH Roff=1e6 Ron=1.0 Voff=0.25 Von=0.75
.ends HICCUP1_U1_U5_S3
*$
.subckt Driver_mod_U1_U4_H1 1 2 3 4
H_U1_U4_H1         3 4 VH_U1_U4_H1 1
VH_U1_U4_H1         1 2 0V
.ends Driver_mod_U1_U4_H1
*$
.subckt Driver_mod_U1_U4_S1 1 2 3 4
S_U1_U4_S1         3 4 1 2 _U1_U4_S1
RS_U1_U4_S1         1 2 1G
.MODEL         _U1_U4_S1 VSWITCH Roff=1e9 Ron=160m Voff=0.2 Von=0.5
.ends Driver_mod_U1_U4_S1
*$
.subckt Driver_mod_U1_U4_S35 1 2 3 4
S_U1_U4_S35         3 4 1 2 _U1_U4_S35
RS_U1_U4_S35         1 2 1G
.MODEL         _U1_U4_S35 VSWITCH Roff=10e6 Ron=1 Voff=0.2 Von=0.8
.ends Driver_mod_U1_U4_S35
*$
.subckt Driver_mod_U1_U4_S2 1 2 3 4
S_U1_U4_S2         3 4 1 2 _U1_U4_S2
RS_U1_U4_S2         1 2 1G
.MODEL         _U1_U4_S2 VSWITCH Roff=1e9 Ron=95m Voff=0.2 Von=0.5
.ends Driver_mod_U1_U4_S2
*$
.subckt Driver_mod_U1_U4_H2 1 2 3 4
H_U1_U4_H2         3 4 VH_U1_U4_H2 -1
VH_U1_U4_H2         1 2 0V
.ends Driver_mod_U1_U4_H2
*$
.subckt Driver_mod_U1_U4_S5 1 2 3 4
S_U1_U4_S5         3 4 1 2 _U1_U4_S5
RS_U1_U4_S5         1 2 1G
.MODEL         _U1_U4_S5 VSWITCH Roff=1e6 Ron=2 Voff=0.2 Von=0.8
.ends Driver_mod_U1_U4_S5
*$
.subckt Driver_mod_U1_U4_S4 1 2 3 4
S_U1_U4_S4         3 4 1 2 _U1_U4_S4
RS_U1_U4_S4         1 2 1G
.MODEL         _U1_U4_S4 VSWITCH Roff=1e6 Ron=2 Voff=0.2 Von=0.8
.ends Driver_mod_U1_U4_S4
*$
.subckt GmIphase_U1_U6_S5 1 2 3 4
S_U1_U6_S5         3 4 1 2 _U1_U6_S5
RS_U1_U6_S5         1 2 1G
.MODEL         _U1_U6_S5 VSWITCH Roff=1e6 Ron=1m Voff=0.25 Von=0.5
.ends GmIphase_U1_U6_S5
*$
.subckt GmIphase_U1_U6_S6 1 2 3 4
S_U1_U6_S6         3 4 1 2 _U1_U6_S6
RS_U1_U6_S6         1 2 1G
.MODEL         _U1_U6_S6 VSWITCH Roff=1e6 Ron=1m Voff=0.25 Von=0.5
.ends GmIphase_U1_U6_S6
*$
.subckt GmIphase_U1_U6_S7 1 2 3 4
S_U1_U6_S7         3 4 1 2 _U1_U6_S7
RS_U1_U6_S7         1 2 1G
.MODEL         _U1_U6_S7 VSWITCH Roff=1 Ron=1e6 Voff=0.2 Von=0.8
.ends GmIphase_U1_U6_S7
*$
.subckt Oscillator_U1_U3_S27 1 2 3 4
S_U1_U3_S27         3 4 1 2 _U1_U3_S27
RS_U1_U3_S27         1 2 1G
.MODEL         _U1_U3_S27 VSWITCH Roff=1e9 Ron=1m Voff=0.25V Von=0.75V
.ends Oscillator_U1_U3_S27
*$
.subckt Oscillator_U1_U3_S26 1 2 3 4
S_U1_U3_S26         3 4 1 2 _U1_U3_S26
RS_U1_U3_S26         1 2 1G
.MODEL         _U1_U3_S26 VSWITCH Roff=1e9 Ron=1m Voff=0.2 Von=0.8
.ends Oscillator_U1_U3_S26
*$
.model D_D d
+ is=1e-015
+ n=0.01
+ tt=1e-011
+ rs=0.05
*$
.model D_D1 d
+ is=1e-015
+ tt=1e-011
+ rs=0.05
+ n=0.1
*$
.subckt dffsr_rhpbasic_gen q qb clk d r s params: vdd=1 vss=0 vthresh=0.5
x1 clk clkdel1 inv_basic_gen params: vdd={vdd} vss={vss} vthresh={vthresh}
r_clk clkdel1 clkdel 21.64502165
c_clk clkdel 0 1n
x2 clk clkdel clkint and2_basic_gen params: vdd={vdd} vss={vss} vthresh=
+ {vthresh}
gq 0 qint value = {if(v(r) > {vthresh},-5,if(v(s) > {vthresh},5, if(v(clkint)>
+  {vthresh},
+ if(v(d)> {vthresh},5,-5),0)))}
cqint qint 0 1n
d_d10 qint my5 d_d1
v1 my5 0 {vdd}
d_d11 myvss qint d_d1
v2 myvss 0 {vss}
eq qqq 0 qint 0 1
x3 qqq qqqd1 buf_delay_basic_gen params: vdd={vdd} vss={vss} vthresh={vthresh}
+  delay = 1n
rqq qqqd1 q 1
eqb qbr 0 value = {if( v(q) > {vthresh}, {vss},{vdd})}
rqb qbr qb 1
cdummy1 q 0 1nf
cdummy2 qb 0 1nf
.ic v(qint) {vss}
.model d_d1 d
+ is=1e-015
+ tt=1e-011
+ rs=0.05
+ n=0.1
.ends dffsr_rhpbasic_gen
*$
.model D_Dton d
+ is=1e-015
+ tt=1e-011
+ rs=0.005
+ n=0.01
*$
.subckt one_shot in out
+ params:  t=100
s_s1         meas 0 reset2 0 s1
e_abm1         ch 0 value { if( v(in)>0.5 | v(out)>0.5,1,0)    }
r_r2         reset2 reset  0.1
e_abm3         out 0 value { if( v(meas)<0.5 & v(ch)>0.5,1,0)    }
r_r1         meas ch  {t}
c_c2         0 reset2  1.4427n
c_c1         0 meas  1.4427n
e_abm2         reset 0 value { if(v(ch)<0.5,1,0)    }
.model s1 vswitch
+ roff=1e+009
+ ron=1
+ voff=0.25
+ von=0.75
.ends one_shot
*$
.SUBCKT OR2_BASIC_GEN A B Y PARAMS: VDD=1 VSS=0 VTHRESH=0.5
E_ABMGATE    YINT 0 VALUE {{IF(V(A) > {VTHRESH}  |
+ V(B) > {VTHRESH},{VDD},{VSS})}}
RINT YINT Y 1
CINT Y 0 1n
.ENDS OR2_BASIC_GEN
*$
.SUBCKT INV_BASIC_GEN A  Y PARAMS: VDD=1 VSS=0 VTHRESH=0.5
E_ABMGATE    YINT 0 VALUE {{IF(V(A) > {VTHRESH} ,
+ {VSS},{VDD})}}
RINT YINT Y 1
CINT Y 0 1n
.ENDS INV_BASIC_GEN
*$
.SUBCKT COMPHYS_BASIC_GEN INP INM HYS OUT PARAMS: VDD=1 VSS=0 VTHRESH=0.5
EIN INP1 INM1 INP INM 1
EHYS INP1 INP2 VALUE { IF( V(1) > {VTHRESH},-V(HYS),0) }
EOUT OUT 0 VALUE { IF( V(INP2)>V(INM1), {VDD} ,{VSS}) }
R1 OUT 1 1
C1 1 0 1n
RINP1 INP1 0 1K
.ENDS COMPHYS_BASIC_GEN
*$
.SUBCKT BUF_DELAY_BASIC_GEN A  Y PARAMS: VDD=1 VSS=0 VTHRESH=0.5 DELAY = 10n
E_ABMGATE1    YINT1 0 VALUE {{IF(V(A) > {VTHRESH} ,
+ {VDD},{VSS})}}
RINT YINT1 YINT2 1
CINT YINT2 0 {DELAY*1.443}
E_ABMGATE2    YINT3 0 VALUE {{IF(V(YINT2) > {VTHRESH} ,
+ {VDD},{VSS})}}
RINT2 YINT3 Y 1
CINT2 Y 0 1n
.ENDS BUF_DELAY_BASIC_GEN
*$
.SUBCKT OR4_BASIC_GEN A B C D Y PARAMS: VDD=1 VSS=0 VTHRESH=0.5
E_ABMGATE    YINT 0 VALUE {{IF(V(A) > {VTHRESH}  |
+ V(B) > {VTHRESH} |
+ V(C) > {VTHRESH} |
+ V(D) > {VTHRESH},{VDD},{VSS})}}
RINT YINT Y 1
CINT Y 0 1n
.ENDS OR4_BASIC_GEN
*$
.SUBCKT AND2_BASIC_GEN A B Y PARAMS: VDD=1 VSS=0 VTHRESH=0.5
E_ABMGATE    YINT 0 VALUE {{IF(V(A) > {VTHRESH}  &
+ V(B) > {VTHRESH},{VDD},{VSS})}}
RINT YINT Y 1
CINT Y 0 1n
.ENDS AND2_BASIC_GEN
*$
.SUBCKT COMP_BASIC_GEN INP INM Y PARAMS: VDD=1 VSS=0 VTHRESH=0.5
E_ABM Yint 0 VALUE {IF (V(INP) >
+ V(INM), {VDD},{VSS})}
R1 Yint Y 1
C1 Y 0 1n
.ENDS COMP_BASIC_GEN
*$
.SUBCKT INV_DELAY_BASIC_GEN A  Y PARAMS: VDD=1 VSS=0 VTHRESH=0.5 DELAY = 10n
E_ABMGATE1    YINT1 0 VALUE {{IF(V(A) > {VTHRESH} ,
+ {VDD},{VSS})}}
RINT YINT1 YINT2 1
CINT YINT2 0 {DELAY*1.3}
E_ABMGATE2    YINT3 0 VALUE {{IF(V(YINT2) > {VTHRESH} ,
+ {VSS},{VDD})}}
RINT2 YINT3 Y 1
CINT2 Y 0 1n
.ENDS INV_DELAY_BASIC_GEN
*$
.SUBCKT SRLATCHRHP_BASIC_GEN S R Q QB PARAMS: VDD=1 VSS=0 VTHRESH=0.5
GQ 0 Qint VALUE = {IF(V(R) > {VTHRESH},-5,IF(V(S)>{VTHRESH},5, 0))}
CQint Qint 0 1n
RQint Qint 0 1000MEG
D_D10 Qint MY5 D_D1
V1 MY5 0 {VDD}
D_D11 MYVSS Qint D_D1
V2 MYVSS 0 {VSS}
EQ Qqq 0 Qint 0 1
X3 Qqq Qqqd1 BUF_BASIC_GEN PARAMS: VDD={VDD} VSS={VSS} VTHRESH={VTHRESH}
RQq Qqqd1 Q 1
EQb Qbr 0 VALUE = {IF( V(Q) > {VTHRESH}, {VSS},{VDD})}
RQb Qbr QB 1
Cdummy1 Q 0 1n
Cdummy2 QB 0 1n
.IC V(Qint) {VSS}
.ENDS SRLATCHRHP_BASIC_GEN
*$
.SUBCKT AND3_BASIC_GEN A B C Y PARAMS: VDD=1 VSS=0 VTHRESH=0.5
E_ABMGATE    YINT 0 VALUE {{IF(V(A) > {VTHRESH}  &
+ V(B) > {VTHRESH} &
+ V(C) > {VTHRESH},{VDD},{VSS})}}
RINT YINT Y 1
CINT Y 0 1n
.ENDS AND3_BASIC_GEN
*$
.SUBCKT OR3_BASIC_GEN A B C Y PARAMS: VDD=1 VSS=0 VTHRESH=0.5
E_ABMGATE    YINT 0 VALUE {{IF(V(A) > {VTHRESH}  |
+ V(B) > {VTHRESH} |
+ V(C) > {VTHRESH},{VDD},{VSS})}}
RINT YINT Y 1
CINT Y 0 1n
.ENDS OR3_BASIC_GEN
*$
.SUBCKT COMPHYS2_BASIC_GEN INP INM HYS OUT PARAMS: VDD=1 VSS=0 VTHRESH=0.5
+ T=10
EIN INP1 INM1 INP INM 1
EHYS INM2 INM1 VALUE { IF( V(1) > {VTHRESH},-V(HYS)/2,V(HYS)/2) }
EOUT OUT 0 VALUE { IF( V(INP1)>V(INM2), {VDD} ,{VSS}) }
R1 OUT 1 1
C1 1 0 {T*1e-9}
RINP1 INP1 0 10K
RINM2 INM2 0 10K
.ENDS COMPHYS2_BASIC_GEN
*$
.SUBCKT NOR2_BASIC_GEN A B Y PARAMS: VDD=1 VSS=0 VTHRESH=0.5
E_ABMGATE    YINT 0 VALUE {{IF(V(A) > {VTHRESH}  |
+ V(B) > {VTHRESH},{VSS},{VDD})}}
RINT YINT Y 1
CINT Y 0 1n
.ENDS NOR2_BASIC_GEN
*$
.SUBCKT MUX2_BASIC_GEN A B S Y PARAMS: VDD=1 VSS=0 VTHRESH=0.5
E_ABMGATE  YINT 0 VALUE {{IF(V(S) > {VTHRESH},
+ V(B),V(A))}}
RINT YINT Y 1
CINT Y 0 1n
.ENDS MUX2_BASIC_GEN
*$
.SUBCKT BUF_BASIC_GEN A  Y PARAMS: VDD=1 VSS=0 VTHRESH=0.5
E_ABMGATE    YINT 0 VALUE {{IF(V(A) > {VTHRESH} ,
+ {VDD},{VSS})}}
RINT YINT Y 1
CINT Y 0 1n
.ENDS BUF_BASIC_GEN
*$
.SUBCKT CESR IN OUT
+ PARAMs:  C=100u ESR=0.01 X=2 IC=0
C	IN 1  {C*X} IC={IC}
RESR	1 OUT {ESR/X}
.ENDS CESR
*$

.end
