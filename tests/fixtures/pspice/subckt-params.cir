* PSPICE PARAMS: subcircuit invocation
.option ngbehavior=ps
.subckt divider in out 0 PARAMS: RUP=1k RDN=1k
R1 in out {RUP}
R2 out 0 {RDN}
.ends divider
V1 in 0 5
X1 in out 0 divider PARAMS: RUP=3k RDN=1k
.print tran v(out)
.tran 1u 20u
.end
