* PSPICE single-ampersand logical operator not supported by this ngspice build
V1 a 0 PULSE(0 1 0 1u 1u 5u 10u)
V2 b 0 1
B1 out 0 V={(V(a) > 0.5) & (V(b) > 0.5)}
R1 out 0 1k
.print tran v(out)
.tran 1u 20u
.end
